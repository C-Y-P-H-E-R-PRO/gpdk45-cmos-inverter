// Portable copy of the archived perf/invertor DC testbench.
// Replace {{MODEL_FILE}} below with the absolute path to your installed GPDK045 Spectre model file.
simulator lang=spectre
global 0
parameters temperature=27 Vdd=1 Vin=0
include "{{MODEL_FILE}}" section=mc

PM0 (Vout net2 net1 net1) g45p1svt w=(120n) l=45n nf=1 as=16.8f ad=16.8f \
        ps=520n pd=520n nrd=1.16667 nrs=1.16667 sa=140n sb=140n sd=160n \
        sca=226.00151 scb=0.11734 scc=0.02767 m=(1)
NM0 (Vout net2 0 0) g45n1svt w=(120n) l=45n nf=1 as=16.8f ad=16.8f ps=520n \
        pd=520n nrd=1.16667 nrs=1.16667 sa=140n sb=140n sd=160n \
        sca=226.00151 scb=0.11734 scc=0.02767 m=(1)
V1 (net1 0) vsource dc=Vdd type=dc
V0 (net2 0) vsource dc=Vin type=dc
simulatorOptions options psfversion="1.4.0" reltol=1e-3 vabstol=1e-6 \
    iabstol=1e-12 temp=27 tnom=27 scalem=1.0 scale=1.0 gmin=1e-12 rforce=1 \
    maxnotes=5 maxwarns=5 digits=5 cols=80 pivrel=1e-3 \
    sensfile="../psf/sens.output" checklimitdest=sqldb
dc dc param=Vin start=0 stop=1 step=0.01 write="spectre.dc" \
    oppoint=rawfile maxiters=150 maxsteps=10000 annotate=status
modelParameter info what=models where=rawfile
element info what=inst where=rawfile
outputParameter info what=output where=rawfile
designParamVals info what=parameters where=rawfile
primitives info what=primitives where=rawfile
subckts info what=subckts where=rawfile
save Vout
saveOptions options save=allpub
