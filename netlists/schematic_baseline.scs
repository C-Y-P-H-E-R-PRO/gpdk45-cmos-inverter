simulator lang=spectre
subckt inverter_schematic (VDD VSS Vin Vout)
PM0 (Vout Vin VDD VDD) g45p1svt w=(120n) l=45n nf=1 as=16.8f ad=16.8f \
        ps=520n pd=520n nrd=1.16667 nrs=1.16667 sa=140n sb=140n sd=160n \
        sca=226.00151 scb=0.11734 scc=0.02767 m=(1)
NM0 (Vout Vin VSS VSS) g45n1svt w=(120n) l=45n nf=1 as=16.8f ad=16.8f ps=520n \
        pd=520n nrd=1.16667 nrs=1.16667 sa=140n sb=140n sd=160n \
        sca=226.00151 scb=0.11734 scc=0.02767 m=(1)
ends inverter_schematic
